**.subckt DrainSelectSchematic SELECT1 DRAIN_MUX DRAIN1 VINJ SELECT2 DRAIN2 SELECT3 DRAIN3 SELECT4 DRAIN4 VGND run_drain1
*+ drain_rail run_drain2 run_drain3 run_drain4
*.ipin SELECT1
*.iopin DRAIN_MUX
*.iopin DRAIN1
*.ipin VINJ
*.ipin SELECT2
*.iopin DRAIN2
*.ipin SELECT3
*.iopin DRAIN3
*.ipin SELECT4
*.iopin DRAIN4
*.iopin VGND
*.ipin run_drain1
*.ipin drain_rail
*.ipin run_drain2
*.ipin run_drain3
*.ipin run_drain4
XM27 net1 SELECT1 VINJ VINJ sky130_fd_pr__pfet_01v8 L=0.15 W=1 nf=1 ad=0.29 as=0.29 pd=2.58 ps=2.58 nrd=0.29 nrs=0.29 sa=0 sb=0
+ sd=0 mult=1 m=1
XM15 net1 SELECT1 VGND VGND sky130_fd_pr__nfet_01v8 L=0.15 W=0.65 nf=1 ad=0.1885 as=0.1885 pd=1.88 ps=1.88 nrd=0.446153846153846
+ nrs=0.446153846153846 sa=0 sb=0 sd=0 mult=1 m=1
XM17 run_drain1 net1 drain_rail VINJ sky130_fd_pr__pfet_01v8 L=0.15 W=2 nf=1 ad=0.58 as=0.58 pd=4.58 ps=4.58 nrd=0.145 nrs=0.145
+ sa=0 sb=0 sd=0 mult=1 m=1
XM18 DRAIN1 net1 DRAIN_MUX VINJ sky130_fd_pr__pfet_01v8 L=0.15 W=2 nf=1 ad=0.58 as=0.58 pd=4.58 ps=4.58 nrd=0.145 nrs=0.145 sa=0
+ sb=0 sd=0 mult=1 m=1
XM26 VINJ SELECT1 DRAIN1 VINJ sky130_fd_pr__pfet_01v8 L=0.15 W=2 nf=1 ad=0.58 as=0.58 pd=4.58 ps=4.58 nrd=0.145 nrs=0.145 sa=0
+ sb=0 sd=0 mult=1 m=1
XM19 run_drain1 SELECT1 drain_rail VGND sky130_fd_pr__nfet_01v8 L=0.15 W=1.3 nf=1 ad=0.377 as=0.377 pd=3.18 ps=3.18
+ nrd=0.223076923076923 nrs=0.223076923076923 sa=0 sb=0 sd=0 mult=1 m=1
XM28 DRAIN1 SELECT1 DRAIN_MUX VGND sky130_fd_pr__nfet_01v8 L=0.15 W=1.3 nf=1 ad=0.377 as=0.377 pd=3.18 ps=3.18
+ nrd=0.223076923076923 nrs=0.223076923076923 sa=0 sb=0 sd=0 mult=1 m=1
XM1 net2 SELECT2 VINJ VINJ sky130_fd_pr__pfet_01v8 L=0.15 W=1 nf=1 ad=0.29 as=0.29 pd=2.58 ps=2.58 nrd=0.29 nrs=0.29 sa=0 sb=0
+ sd=0 mult=1 m=1
XM2 net2 SELECT2 VGND VGND sky130_fd_pr__nfet_01v8 L=0.15 W=0.65 nf=1 ad=0.1885 as=0.1885 pd=1.88 ps=1.88 nrd=0.446153846153846
+ nrs=0.446153846153846 sa=0 sb=0 sd=0 mult=1 m=1
XM3 run_drain2 net2 drain_rail VINJ sky130_fd_pr__pfet_01v8 L=0.15 W=2 nf=1 ad=0.58 as=0.58 pd=4.58 ps=4.58 nrd=0.145 nrs=0.145
+ sa=0 sb=0 sd=0 mult=1 m=1
XM4 DRAIN2 net2 DRAIN_MUX VINJ sky130_fd_pr__pfet_01v8 L=0.15 W=2 nf=1 ad=0.58 as=0.58 pd=4.58 ps=4.58 nrd=0.145 nrs=0.145 sa=0
+ sb=0 sd=0 mult=1 m=1
XM5 VINJ SELECT2 DRAIN2 VINJ sky130_fd_pr__pfet_01v8 L=0.15 W=2 nf=1 ad=0.58 as=0.58 pd=4.58 ps=4.58 nrd=0.145 nrs=0.145 sa=0 sb=0
+ sd=0 mult=1 m=1
XM6 run_drain2 SELECT2 drain_rail VGND sky130_fd_pr__nfet_01v8 L=0.15 W=1.3 nf=1 ad=0.377 as=0.377 pd=3.18 ps=3.18
+ nrd=0.223076923076923 nrs=0.223076923076923 sa=0 sb=0 sd=0 mult=1 m=1
XM7 DRAIN2 SELECT2 DRAIN_MUX VGND sky130_fd_pr__nfet_01v8 L=0.15 W=1.3 nf=1 ad=0.377 as=0.377 pd=3.18 ps=3.18
+ nrd=0.223076923076923 nrs=0.223076923076923 sa=0 sb=0 sd=0 mult=1 m=1
XM8 net3 SELECT3 VINJ VINJ sky130_fd_pr__pfet_01v8 L=0.15 W=1 nf=1 ad=0.29 as=0.29 pd=2.58 ps=2.58 nrd=0.29 nrs=0.29 sa=0 sb=0
+ sd=0 mult=1 m=1
XM9 net3 SELECT3 VGND VGND sky130_fd_pr__nfet_01v8 L=0.15 W=0.65 nf=1 ad=0.1885 as=0.1885 pd=1.88 ps=1.88 nrd=0.446153846153846
+ nrs=0.446153846153846 sa=0 sb=0 sd=0 mult=1 m=1
XM10 run_drain3 net3 drain_rail VINJ sky130_fd_pr__pfet_01v8 L=0.15 W=2 nf=1 ad=0.58 as=0.58 pd=4.58 ps=4.58 nrd=0.145 nrs=0.145
+ sa=0 sb=0 sd=0 mult=1 m=1
XM11 DRAIN3 net3 DRAIN_MUX VINJ sky130_fd_pr__pfet_01v8 L=0.15 W=2 nf=1 ad=0.58 as=0.58 pd=4.58 ps=4.58 nrd=0.145 nrs=0.145 sa=0
+ sb=0 sd=0 mult=1 m=1
XM12 VINJ SELECT3 DRAIN3 VINJ sky130_fd_pr__pfet_01v8 L=0.15 W=2 nf=1 ad=0.58 as=0.58 pd=4.58 ps=4.58 nrd=0.145 nrs=0.145 sa=0
+ sb=0 sd=0 mult=1 m=1
XM13 run_drain3 SELECT3 drain_rail VGND sky130_fd_pr__nfet_01v8 L=0.15 W=1.3 nf=1 ad=0.377 as=0.377 pd=3.18 ps=3.18
+ nrd=0.223076923076923 nrs=0.223076923076923 sa=0 sb=0 sd=0 mult=1 m=1
XM14 DRAIN3 SELECT3 DRAIN_MUX VGND sky130_fd_pr__nfet_01v8 L=0.15 W=1.3 nf=1 ad=0.377 as=0.377 pd=3.18 ps=3.18
+ nrd=0.223076923076923 nrs=0.223076923076923 sa=0 sb=0 sd=0 mult=1 m=1
XM16 net4 SELECT4 VINJ VINJ sky130_fd_pr__pfet_01v8 L=0.15 W=1 nf=1 ad=0.29 as=0.29 pd=2.58 ps=2.58 nrd=0.29 nrs=0.29 sa=0 sb=0
+ sd=0 mult=1 m=1
XM20 net4 SELECT4 VGND VGND sky130_fd_pr__nfet_01v8 L=0.15 W=0.65 nf=1 ad=0.1885 as=0.1885 pd=1.88 ps=1.88 nrd=0.446153846153846
+ nrs=0.446153846153846 sa=0 sb=0 sd=0 mult=1 m=1
XM21 run_drain4 net4 drain_rail VINJ sky130_fd_pr__pfet_01v8 L=0.15 W=2 nf=1 ad=0.58 as=0.58 pd=4.58 ps=4.58 nrd=0.145 nrs=0.145
+ sa=0 sb=0 sd=0 mult=1 m=1
XM22 DRAIN4 net4 DRAIN_MUX VINJ sky130_fd_pr__pfet_01v8 L=0.15 W=2 nf=1 ad=0.58 as=0.58 pd=4.58 ps=4.58 nrd=0.145 nrs=0.145 sa=0
+ sb=0 sd=0 mult=1 m=1
XM23 VINJ SELECT4 DRAIN4 VINJ sky130_fd_pr__pfet_01v8 L=0.15 W=2 nf=1 ad=0.58 as=0.58 pd=4.58 ps=4.58 nrd=0.145 nrs=0.145 sa=0
+ sb=0 sd=0 mult=1 m=1
XM24 run_drain4 SELECT4 drain_rail VGND sky130_fd_pr__nfet_01v8 L=0.15 W=1.3 nf=1 ad=0.377 as=0.377 pd=3.18 ps=3.18
+ nrd=0.223076923076923 nrs=0.223076923076923 sa=0 sb=0 sd=0 mult=1 m=1
XM25 DRAIN4 SELECT4 DRAIN_MUX VGND sky130_fd_pr__nfet_01v8 L=0.15 W=1.3 nf=1 ad=0.377 as=0.377 pd=3.18 ps=3.18
+ nrd=0.223076923076923 nrs=0.223076923076923 sa=0 sb=0 sd=0 mult=1 m=1
**.ends
.GLOBAL VGND
.end
