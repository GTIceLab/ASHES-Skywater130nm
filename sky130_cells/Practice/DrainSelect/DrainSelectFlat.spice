* NGSPICE file created from DrainSelectFlat.ext - technology: sky130A

X0 a_n1920_270# a_n1940_255# a_n1920_226# a_n1888_353# sky130_fd_pr__nfet_01v8 ad=0.377 pd=3.18 as=0.377 ps=3.18 w=1.3 l=0.15
X1 a_n1070_340# a_n1419_363# a_n1920_226# a_n1888_353# sky130_fd_pr__nfet_01v8 ad=0.377 pd=3.18 as=0.377 ps=3.18 w=1.3 l=0.15
X2 a_n1070_544# a_n1368_548# a_n1920_226# w_n1720_200# sky130_fd_pr__pfet_01v8 ad=0.38 pd=2.38 as=0.6 ps=4.6 w=2 l=0.15
X3 a_n1888_353# a_n1419_159# a_n1070_136# w_n1720_200# sky130_fd_pr__pfet_01v8 ad=0.81512 pd=6.8 as=0.38 ps=2.38 w=2 l=0.15
X4 a_n1918_160# a_n1368_344# a_n548_320# w_n1720_200# sky130_fd_pr__pfet_01v8 ad=0.6 pd=4.6 as=0.6 ps=4.6 w=2 l=0.15
X5 a_n1918_160# a_n1820_390# a_n1918_116# w_n1720_200# sky130_fd_pr__pfet_01v8 ad=0.6 pd=4.6 as=0.6 ps=4.6 w=2 l=0.15
X6 a_n1918_160# a_n1368_548# a_n548_524# w_n1720_200# sky130_fd_pr__pfet_01v8 ad=0.6 pd=4.6 as=0.6 ps=4.6 w=2 l=0.15
X7 a_n1920_270# a_n1820_390# a_n1920_226# w_n1720_200# sky130_fd_pr__pfet_01v8 ad=0.38 pd=2.38 as=0.6 ps=4.6 w=2 l=0.15
X8 a_n1918_160# a_n1940_255# a_n1918_116# a_n1888_353# sky130_fd_pr__nfet_01v8 ad=0.377 pd=3.18 as=0.377 ps=3.18 w=1.3 l=0.15
X9 a_n1070_136# a_n1419_159# a_n1920_226# a_n1888_353# sky130_fd_pr__nfet_01v8 ad=0.377 pd=3.18 as=0.377 ps=3.18 w=1.3 l=0.15
X10 a_n1888_353# a_n1940_255# a_n1820_390# w_n1720_200# sky130_fd_pr__pfet_01v8 ad=0.40756 pd=3.4 as=0.27 ps=2.54 w=1 l=0.15
X11 a_n1070_340# a_n1368_344# a_n1920_226# w_n1720_200# sky130_fd_pr__pfet_01v8 ad=0.38 pd=2.38 as=0.6 ps=4.6 w=2 l=0.15
X12 a_n1918_160# a_n1368_140# a_n548_116# w_n1720_200# sky130_fd_pr__pfet_01v8 ad=0.6 pd=4.6 as=0.6 ps=4.6 w=2 l=0.15
X13 a_n1888_353# a_n1419_567# a_n1368_548# w_n1720_200# sky130_fd_pr__pfet_01v8 ad=0.40756 pd=3.4 as=0.27 ps=2.54 w=1 l=0.15
X14 w_n1720_200# a_n1419_567# a_n1368_548# a_n1888_353# sky130_fd_pr__nfet_01v8 ad=1.39735 pd=7.38 as=0.1755 ps=1.84 w=0.65 l=0.15
X15 a_n1888_353# a_n1940_255# a_n1920_270# w_n1720_200# sky130_fd_pr__pfet_01v8 ad=0.81512 pd=6.8 as=0.38 ps=2.38 w=2 l=0.15
X16 a_n1918_160# a_n1419_363# a_n548_320# a_n1888_353# sky130_fd_pr__nfet_01v8 ad=0.377 pd=3.18 as=0.377 ps=3.18 w=1.3 l=0.15
X17 a_n1918_160# a_n1419_567# a_n548_524# a_n1888_353# sky130_fd_pr__nfet_01v8 ad=0.377 pd=3.18 as=0.377 ps=3.18 w=1.3 l=0.15
X18 w_n1720_200# a_n1940_255# a_n1820_390# a_n1888_353# sky130_fd_pr__nfet_01v8 ad=1.39735 pd=7.38 as=0.1755 ps=1.84 w=0.65 l=0.15
X19 a_n1070_136# a_n1368_140# a_n1920_226# w_n1720_200# sky130_fd_pr__pfet_01v8 ad=0.38 pd=2.38 as=0.6 ps=4.6 w=2 l=0.15
X20 a_n1888_353# a_n1419_159# a_n1368_140# w_n1720_200# sky130_fd_pr__pfet_01v8 ad=0.40756 pd=3.4 as=0.27 ps=2.54 w=1 l=0.15
X21 w_n1720_200# a_n1419_159# a_n1368_140# a_n1888_353# sky130_fd_pr__nfet_01v8 ad=1.39735 pd=7.38 as=0.1755 ps=1.84 w=0.65 l=0.15
X22 a_n1888_353# a_n1419_363# a_n1368_344# w_n1720_200# sky130_fd_pr__pfet_01v8 ad=0.40756 pd=3.4 as=0.27 ps=2.54 w=1 l=0.15
X23 w_n1720_200# a_n1419_363# a_n1368_344# a_n1888_353# sky130_fd_pr__nfet_01v8 ad=1.39735 pd=7.38 as=0.1755 ps=1.84 w=0.65 l=0.15
X24 a_n1918_160# a_n1419_159# a_n548_116# a_n1888_353# sky130_fd_pr__nfet_01v8 ad=0.377 pd=3.18 as=0.377 ps=3.18 w=1.3 l=0.15
X25 a_n1070_544# a_n1419_567# a_n1920_226# a_n1888_353# sky130_fd_pr__nfet_01v8 ad=0.377 pd=3.18 as=0.377 ps=3.18 w=1.3 l=0.15
X26 a_n1888_353# a_n1419_363# a_n1070_340# w_n1720_200# sky130_fd_pr__pfet_01v8 ad=0.81512 pd=6.8 as=0.38 ps=2.38 w=2 l=0.15
X27 a_n1888_353# a_n1419_567# a_n1070_544# w_n1720_200# sky130_fd_pr__pfet_01v8 ad=0.81512 pd=6.8 as=0.38 ps=2.38 w=2 l=0.15
