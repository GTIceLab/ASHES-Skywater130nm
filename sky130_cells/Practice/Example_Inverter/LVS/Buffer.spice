* NGSPICE file created from Buffer.ext - technology: sky130A

.subckt Buffer VDD GND I Z
X0 Z a_16_n12# VDD VDD sky130_fd_pr__pfet_01v8 ad=0.47 pd=2.94 as=0.29 ps=2.58 w=1 l=0.15
**devattr s=2900,258 d=4700,294
X1 a_16_n12# I VDD VDD sky130_fd_pr__pfet_01v8 ad=0.47 pd=2.94 as=0.29 ps=2.58 w=1 l=0.15
**devattr s=2900,258 d=4700,294
X2 Z a_16_n12# GND GND sky130_fd_pr__nfet_01v8 ad=0.44 pd=2.88 as=0.29 ps=2.58 w=1 l=0.15
**devattr s=2900,258 d=4400,288
X3 a_16_n12# I GND GND sky130_fd_pr__nfet_01v8 ad=0.44 pd=2.88 as=0.29 ps=2.58 w=1 l=0.15
**devattr s=2900,258 d=4400,288
.ends
