* NGSPICE file created from Example_Inverter.ext - technology: sky130A

.subckt Example_Inverter VDD I Z GND
X0 Z I GND GND sky130_fd_pr__nfet_01v8 ad=0.44 pd=2.88 as=0.29 ps=2.58 w=1 l=0.15
X1 Z I VDD VDD sky130_fd_pr__pfet_01v8 ad=0.47 pd=2.94 as=0.29 ps=2.58 w=1 l=0.15
.ends
