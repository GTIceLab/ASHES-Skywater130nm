* NGSPICE file created from G_or_S_IndrctSwcs.ext - technology: sky130A

.subckt G_or_S_IndrctSwcs GND AVDD VINJ prog run Vgrun fg_pu(0) fg_pu(1) Vs_AorB_mtrx(0)
+ Vs_AorB_mtrx(1) Vg_AorB_mtrx(0) Vg_AorB_mtrx(1) Input(0) Input(1) Vg_global(0) Vg_global(1)
X0 a_665_933# a_352_920# Vgrun VINJ sky130_fd_pr__pfet_g5v0d10v5 ad=0.43333 pd=3.1 as=0.6 ps=4.6 w=2 l=0.5
**devattr s=6000,460 d=3500,235
X1 Input(0) a_340_553# a_665_933# VINJ sky130_fd_pr__pfet_g5v0d10v5 ad=0.6 pd=4.6 as=0.43333 ps=3.1 w=2 l=0.5
**devattr s=3500,235 d=6000,460
X2 Input(1) a_1335_945# a_1852_933# VINJ sky130_fd_pr__pfet_g5v0d10v5 ad=0.6 pd=4.6 as=0.43333 ps=3.1 w=2 l=0.5
**devattr s=3500,235 d=6000,460
X3 a_340_553# a_352_920# GND GND sky130_fd_pr__nfet_01v8 ad=0.126 pd=1.44 as=0.091 ps=0.99333 w=0.42 l=0.15
**devattr s=735,77 d=1260,144
X4 GND fg_pu(0) a_352_920# GND sky130_fd_pr__nfet_01v8 ad=0.091 pd=0.99333 as=0.126 ps=1.44 w=0.42 l=0.15
**devattr s=1260,144 d=735,77
X5 fg_pu(1) fg_pu(1) a_1301_665# GND sky130_fd_pr__nfet_01v8 ad=0.126 pd=1.44 as=0.0735 ps=0.77 w=0.42 l=0.5
**devattr s=735,77 d=1260,144
X6 a_1852_933# a_1309_890# AVDD VINJ sky130_fd_pr__pfet_g5v0d10v5 ad=0.43333 pd=3.1 as=0.6 ps=4.6 w=2 l=0.5
**devattr s=6000,460 d=3500,235
X7 AVDD fg_pu(0) a_352_920# VINJ sky130_fd_pr__pfet_01v8 ad=0.0735 pd=0.77 as=0.126 ps=1.44 w=0.42 l=0.15
**devattr s=1260,144 d=735,77
X8 a_340_553# a_352_920# AVDD VINJ sky130_fd_pr__pfet_01v8 ad=0.126 pd=1.44 as=0.0735 ps=0.77 w=0.42 l=0.15
**devattr s=735,77 d=1260,144
X9 Input(1) a_1335_945# a_1489_536# GND sky130_fd_pr__nfet_g5v0d10v5 ad=0.39 pd=3.2 as=0.30333 ps=2.2 w=1.3 l=0.5
**devattr s=2600,170 d=3900,320
X10 Vg_global(1) prog Vg_AorB_mtrx(1) GND sky130_fd_pr__nfet_g5v0d10v5 ad=0.39 pd=3.2 as=0.26 ps=1.7 w=1.3 l=0.5
**devattr s=2600,170 d=3900,320
X11 a_1489_536# a_1309_890# Vgrun GND sky130_fd_pr__nfet_g5v0d10v5 ad=0.30333 pd=2.2 as=0.39 ps=3.2 w=1.3 l=0.5
**devattr s=3900,320 d=2600,170
X12 a_322_43# a_352_920# Input(0) VINJ sky130_fd_pr__pfet_g5v0d10v5 ad=0.43333 pd=3.1 as=0.6 ps=4.6 w=2 l=0.5
**devattr s=6000,460 d=3500,235
X13 Vg_AorB_mtrx(1) run a_1489_536# GND sky130_fd_pr__nfet_g5v0d10v5 ad=0.26 pd=1.7 as=0.30333 ps=2.2 w=1.3 l=0.5
**devattr s=3900,320 d=2600,170
X14 Vg_global(1) run Vg_AorB_mtrx(1) VINJ sky130_fd_pr__pfet_g5v0d10v5 ad=0.6 pd=4.6 as=0.35 ps=2.35 w=2 l=0.5
**devattr s=3500,235 d=6000,460
X15 a_878_665# a_878_665# GND GND sky130_fd_pr__nfet_01v8 ad=0.0735 pd=0.77 as=0.091 ps=0.99333 w=0.42 l=0.5
**devattr s=1260,144 d=735,77
X16 Vs_AorB_mtrx(0) prog a_322_43# VINJ sky130_fd_pr__pfet_g5v0d10v5 ad=0.35 pd=2.35 as=0.43333 ps=3.1 w=2 l=0.5
**devattr s=6000,460 d=3500,235
X17 a_1335_945# fg_pu(1) GND GND sky130_fd_pr__nfet_01v8 ad=0.126 pd=1.44 as=0.091 ps=0.99333 w=0.42 l=0.15
**devattr s=735,77 d=1260,144
X18 AVDD a_340_553# a_322_43# VINJ sky130_fd_pr__pfet_g5v0d10v5 ad=0.6 pd=4.6 as=0.43333 ps=3.1 w=2 l=0.5
**devattr s=3500,235 d=6000,460
X19 Input(1) a_1309_890# a_1852_933# GND sky130_fd_pr__nfet_g5v0d10v5 ad=0.39 pd=3.2 as=0.26 ps=1.7 w=1.3 l=0.5
**devattr s=2600,170 d=3900,320
X20 Vs_AorB_mtrx(0) run a_322_43# GND sky130_fd_pr__nfet_g5v0d10v5 ad=0.39 pd=3.2 as=0.26 ps=1.7 w=1.3 l=0.5
**devattr s=2600,170 d=3900,320
X21 a_322_43# a_340_553# Input(0) GND sky130_fd_pr__nfet_g5v0d10v5 ad=0.26 pd=1.7 as=0.39 ps=3.2 w=1.3 l=0.5
**devattr s=3900,320 d=2600,170
X22 a_665_933# prog Vg_AorB_mtrx(0) VINJ sky130_fd_pr__pfet_g5v0d10v5 ad=0.43333 pd=3.1 as=0.35 ps=2.35 w=2 l=0.5
**devattr s=3500,235 d=6000,460
X23 Vs_AorB_mtrx(1) run AVDD VINJ sky130_fd_pr__pfet_g5v0d10v5 ad=0.35 pd=2.35 as=0.6 ps=4.6 w=2 l=0.5
**devattr s=6000,460 d=3500,235
X24 a_1335_945# fg_pu(1) AVDD VINJ sky130_fd_pr__pfet_01v8 ad=0.126 pd=1.44 as=0.0735 ps=0.77 w=0.42 l=0.15
**devattr s=735,77 d=1260,144
X25 a_1489_536# a_1309_890# Input(1) VINJ sky130_fd_pr__pfet_g5v0d10v5 ad=0.43333 pd=3.1 as=0.6 ps=4.6 w=2 l=0.5
**devattr s=6000,460 d=3500,235
X26 AVDD run Vs_AorB_mtrx(0) VINJ sky130_fd_pr__pfet_g5v0d10v5 ad=0.6 pd=4.6 as=0.35 ps=2.35 w=2 l=0.5
**devattr s=3500,235 d=6000,460
X27 Vg_AorB_mtrx(1) prog a_1489_536# VINJ sky130_fd_pr__pfet_g5v0d10v5 ad=0.35 pd=2.35 as=0.43333 ps=3.1 w=2 l=0.5
**devattr s=6000,460 d=3500,235
X28 Vgrun a_1335_945# a_1489_536# VINJ sky130_fd_pr__pfet_g5v0d10v5 ad=0.6 pd=4.6 as=0.43333 ps=3.1 w=2 l=0.5
**devattr s=3500,235 d=6000,460
X29 GND a_1335_945# a_1309_890# GND sky130_fd_pr__nfet_01v8 ad=0.091 pd=0.99333 as=0.126 ps=1.44 w=0.42 l=0.15
**devattr s=1260,144 d=735,77
X30 fg_pu(0) fg_pu(0) a_878_665# GND sky130_fd_pr__nfet_01v8 ad=0.126 pd=1.44 as=0.0735 ps=0.77 w=0.42 l=0.5
**devattr s=735,77 d=1260,144
X31 Vgrun a_340_553# a_665_933# GND sky130_fd_pr__nfet_g5v0d10v5 ad=0.39 pd=3.2 as=0.30333 ps=2.2 w=1.3 l=0.5
**devattr s=2600,170 d=3900,320
X32 a_665_933# run Vg_AorB_mtrx(0) GND sky130_fd_pr__nfet_g5v0d10v5 ad=0.30333 pd=2.2 as=0.26 ps=1.7 w=1.3 l=0.5
**devattr s=2600,170 d=3900,320
X33 a_1852_933# run Vs_AorB_mtrx(1) GND sky130_fd_pr__nfet_g5v0d10v5 ad=0.26 pd=1.7 as=0.39 ps=3.2 w=1.3 l=0.5
**devattr s=3900,320 d=2600,170
X34 a_665_933# a_352_920# Input(0) GND sky130_fd_pr__nfet_g5v0d10v5 ad=0.30333 pd=2.2 as=0.39 ps=3.2 w=1.3 l=0.5
**devattr s=3900,320 d=2600,170
X35 Vg_AorB_mtrx(0) prog Vg_global(0) GND sky130_fd_pr__nfet_g5v0d10v5 ad=0.26 pd=1.7 as=0.39 ps=3.2 w=1.3 l=0.5
**devattr s=3900,320 d=2600,170
X36 Vg_AorB_mtrx(0) run Vg_global(0) VINJ sky130_fd_pr__pfet_g5v0d10v5 ad=0.35 pd=2.35 as=0.6 ps=4.6 w=2 l=0.5
**devattr s=6000,460 d=3500,235
X37 a_1852_933# prog Vs_AorB_mtrx(1) VINJ sky130_fd_pr__pfet_g5v0d10v5 ad=0.43333 pd=3.1 as=0.35 ps=2.35 w=2 l=0.5
**devattr s=3500,235 d=6000,460
X38 AVDD a_1335_945# a_1309_890# VINJ sky130_fd_pr__pfet_01v8 ad=0.0735 pd=0.77 as=0.126 ps=1.44 w=0.42 l=0.15
**devattr s=1260,144 d=735,77
X39 a_1301_665# a_1301_665# GND GND sky130_fd_pr__nfet_01v8 ad=0.0735 pd=0.77 as=0.091 ps=0.99333 w=0.42 l=0.5
**devattr s=1260,144 d=735,77
.ends
