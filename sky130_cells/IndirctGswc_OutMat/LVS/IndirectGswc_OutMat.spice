* NGSPICE file created from IndirectGswc_OutMat.ext - technology: sky130A

.subckt IndirectGswc_OutMat GND AVDD VINJ prog run Vgrun fg_pu(0) Vs_global(1) Vs_out_mtrx(1)
+ Vg_out_mtrx(1) fg_pu(1) Vg_out_mtrx(0) Vs_out_mtrx(0) Vs_global(0) Vg_global(0)
+ Vg_global(1)
X0 Vs_global(1) a_1335_945# a_1659_736# VINJ sky130_fd_pr__pfet_g5v0d10v5 ad=0.6 pd=4.6 as=0.43333 ps=3.1 w=2 l=0.5
**devattr s=3500,235 d=6000,460
X1 a_340_553# a_352_920# GND GND sky130_fd_pr__nfet_01v8 ad=0.126 pd=1.44 as=0.091 ps=0.99333 w=0.42 l=0.15
**devattr s=735,77 d=1260,144
X2 GND fg_pu(0) a_352_920# GND sky130_fd_pr__nfet_01v8 ad=0.091 pd=0.99333 as=0.126 ps=1.44 w=0.42 l=0.15
**devattr s=1260,144 d=735,77
X3 Vg_global(0) a_352_920# a_322_43# GND sky130_fd_pr__nfet_g5v0d10v5 ad=0.4485 pd=3.29 as=0.30333 ps=2.2 w=1.3 l=0.5
**devattr s=3900,320 d=5070,338
X4 fg_pu(1) fg_pu(1) a_1301_665# GND sky130_fd_pr__nfet_01v8 ad=0.126 pd=1.44 as=0.0735 ps=0.77 w=0.42 l=0.5
**devattr s=735,77 d=1260,144
X5 a_1659_736# a_1309_890# Vg_global(1) VINJ sky130_fd_pr__pfet_g5v0d10v5 ad=0.43333 pd=3.1 as=0.6 ps=4.6 w=2 l=0.5
**devattr s=6000,460 d=3500,235
X6 AVDD fg_pu(0) a_352_920# VINJ sky130_fd_pr__pfet_01v8 ad=0.0735 pd=0.77 as=0.126 ps=1.44 w=0.42 l=0.15
**devattr s=1260,144 d=735,77
X7 a_340_553# a_352_920# AVDD VINJ sky130_fd_pr__pfet_01v8 ad=0.126 pd=1.44 as=0.0735 ps=0.77 w=0.42 l=0.15
**devattr s=735,77 d=1260,144
X8 Vg_global(1) prog Vg_out_mtrx(1) GND sky130_fd_pr__nfet_g5v0d10v5 ad=0.4485 pd=3.29 as=0.26 ps=1.7 w=1.3 l=0.5
**devattr s=2600,170 d=3900,320
X9 a_322_43# a_352_920# Vs_global(0) VINJ sky130_fd_pr__pfet_g5v0d10v5 ad=0.43333 pd=3.1 as=0.6 ps=4.6 w=2 l=0.5
**devattr s=6000,460 d=3500,235
X10 Vg_out_mtrx(1) run Vgrun GND sky130_fd_pr__nfet_g5v0d10v5 ad=0.26 pd=1.7 as=0.39 ps=3.2 w=1.3 l=0.5
**devattr s=3900,320 d=2600,170
X11 Vg_global(1) run Vg_out_mtrx(1) VINJ sky130_fd_pr__pfet_g5v0d10v5 ad=0.6 pd=4.6 as=0.35 ps=2.35 w=2 l=0.5
**devattr s=3500,235 d=6000,460
X12 a_878_665# a_878_665# GND GND sky130_fd_pr__nfet_01v8 ad=0.0735 pd=0.77 as=0.091 ps=0.99333 w=0.42 l=0.5
**devattr s=1260,144 d=735,77
X13 Vs_out_mtrx(0) prog a_322_43# VINJ sky130_fd_pr__pfet_g5v0d10v5 ad=0.35 pd=2.35 as=0.43333 ps=3.1 w=2 l=0.5
**devattr s=6000,460 d=3500,235
X14 a_1335_945# fg_pu(1) GND GND sky130_fd_pr__nfet_01v8 ad=0.126 pd=1.44 as=0.091 ps=0.99333 w=0.42 l=0.15
**devattr s=735,77 d=1260,144
X15 Vg_global(0) a_340_553# a_322_43# VINJ sky130_fd_pr__pfet_g5v0d10v5 ad=0.6 pd=4.6 as=0.43333 ps=3.1 w=2 l=0.5
**devattr s=3500,235 d=6000,460
X16 Vs_global(1) a_1309_890# a_1659_736# GND sky130_fd_pr__nfet_g5v0d10v5 ad=0.39 pd=3.2 as=0.30333 ps=2.2 w=1.3 l=0.5
**devattr s=2600,170 d=3900,320
X17 Vs_out_mtrx(0) run a_322_43# GND sky130_fd_pr__nfet_g5v0d10v5 ad=0.39 pd=3.2 as=0.30333 ps=2.2 w=1.3 l=0.5
**devattr s=2600,170 d=3900,320
X18 a_322_43# a_340_553# Vs_global(0) GND sky130_fd_pr__nfet_g5v0d10v5 ad=0.30333 pd=2.2 as=0.39 ps=3.2 w=1.3 l=0.5
**devattr s=3900,320 d=2600,170
X19 Vgrun prog Vg_out_mtrx(0) VINJ sky130_fd_pr__pfet_g5v0d10v5 ad=0.6 pd=4.6 as=0.35 ps=2.35 w=2 l=0.5
**devattr s=3500,235 d=6000,460
X20 Vs_out_mtrx(1) run AVDD VINJ sky130_fd_pr__pfet_g5v0d10v5 ad=0.35 pd=2.35 as=0.6 ps=4.6 w=2 l=0.5
**devattr s=6000,460 d=3500,235
X21 a_1335_945# fg_pu(1) AVDD VINJ sky130_fd_pr__pfet_01v8 ad=0.126 pd=1.44 as=0.0735 ps=0.77 w=0.42 l=0.15
**devattr s=735,77 d=1260,144
X22 AVDD run Vs_out_mtrx(0) VINJ sky130_fd_pr__pfet_g5v0d10v5 ad=0.6 pd=4.6 as=0.35 ps=2.35 w=2 l=0.5
**devattr s=3500,235 d=6000,460
X23 Vg_out_mtrx(1) prog Vgrun VINJ sky130_fd_pr__pfet_g5v0d10v5 ad=0.35 pd=2.35 as=0.6 ps=4.6 w=2 l=0.5
**devattr s=6000,460 d=3500,235
X24 a_1659_736# a_1335_945# Vg_global(1) GND sky130_fd_pr__nfet_g5v0d10v5 ad=0.30333 pd=2.2 as=0.4485 ps=3.29 w=1.3 l=0.5
**devattr s=5070,338 d=3900,320
X25 GND a_1335_945# a_1309_890# GND sky130_fd_pr__nfet_01v8 ad=0.091 pd=0.99333 as=0.126 ps=1.44 w=0.42 l=0.15
**devattr s=1260,144 d=735,77
X26 fg_pu(0) fg_pu(0) a_878_665# GND sky130_fd_pr__nfet_01v8 ad=0.126 pd=1.44 as=0.0735 ps=0.77 w=0.42 l=0.5
**devattr s=735,77 d=1260,144
X27 Vgrun run Vg_out_mtrx(0) GND sky130_fd_pr__nfet_g5v0d10v5 ad=0.39 pd=3.2 as=0.26 ps=1.7 w=1.3 l=0.5
**devattr s=2600,170 d=3900,320
X28 a_1659_736# run Vs_out_mtrx(1) GND sky130_fd_pr__nfet_g5v0d10v5 ad=0.30333 pd=2.2 as=0.39 ps=3.2 w=1.3 l=0.5
**devattr s=3900,320 d=2600,170
X29 Vg_out_mtrx(0) prog Vg_global(0) GND sky130_fd_pr__nfet_g5v0d10v5 ad=0.26 pd=1.7 as=0.4485 ps=3.29 w=1.3 l=0.5
**devattr s=3900,320 d=2600,170
X30 Vg_out_mtrx(0) run Vg_global(0) VINJ sky130_fd_pr__pfet_g5v0d10v5 ad=0.35 pd=2.35 as=0.6 ps=4.6 w=2 l=0.5
**devattr s=6000,460 d=3500,235
X31 a_1659_736# prog Vs_out_mtrx(1) VINJ sky130_fd_pr__pfet_g5v0d10v5 ad=0.43333 pd=3.1 as=0.35 ps=2.35 w=2 l=0.5
**devattr s=3500,235 d=6000,460
X32 AVDD a_1335_945# a_1309_890# VINJ sky130_fd_pr__pfet_01v8 ad=0.0735 pd=0.77 as=0.126 ps=1.44 w=0.42 l=0.15
**devattr s=1260,144 d=735,77
X33 a_1301_665# a_1301_665# GND GND sky130_fd_pr__nfet_01v8 ad=0.0735 pd=0.77 as=0.091 ps=0.99333 w=0.42 l=0.5
**devattr s=1260,144 d=735,77
.ends
