**.subckt sky130_hilas_CellVoltageDAC01 VINJ[2],VINJ[1],VINJ[0] ENABLE IN[1],IN[0] Out VREFin VREFout VGND
*.iopin VINJ[2],VINJ[1],VINJ[0]
*.opin Out
*.iopin VREFout
*.ipin ENABLE
*.ipin IN[1],IN[0]
*.iopin VREFin
*.iopin VGND
x1 VINJ[2] VREFin net1 net2 Out net3 net4 VGND VREFout sky130_hilas_dac_cell
x2 VINJ[1] VINJ[0] IN[1] IN[0] ENABLE net1 net2 net3 net4 VGND sky130_hilas_VinjDecode2to4
**.ends

.subckt sky130_hilas_dac_cell VDD VREFin D0 D1 Out D2 D3 GND VREFout
*.iopin VDD
*.opin Out
*.ipin D0
*.ipin D1
*.ipin D2
*.ipin D3
*.iopin GND
*.iopin VREFout
*.iopin VREFin
x1 VDD Out D0 Node[0] GND Tgate
x2 VDD Out D1 Node[1] GND Tgate
x3 VDD Out D2 Node[2] GND Tgate
x4 VDD Out D3 Node[3] GND Tgate
x5 VREFin Node[3] Node[2] Node[1] Node[0] VREFout sky130_hilas_resistor_string
.ends

*+ pins=8
.subckt sky130_hilas_VinjDecode2to4 VINJ[1] VINJ[0] IN[1] IN[0] ENABLE OUTPUT00 OUTPUT01 OUTPUT10 OUTPUT11 VGND
*.ipin ENABLE
*.opin OUTPUT00
*.opin OUTPUT01
*.opin OUTPUT10
*.opin OUTPUT11
*.iopin VINJ[1],VINJ[0]
*.iopin VGND
*.ipin IN[1],IN[0]
x2 VINJ[0] IN[1] VinjNOR3_2/Input2 VGND sky130_hilas_VinjInv2
x3 VINJ[0] IN[0] VinjNOR3_1/Input1 VGND sky130_hilas_VinjInv2
x4 VINJ[0] ENABLE VinjNOR3_3/Input3 VGND sky130_hilas_VinjInv2
x1 VINJ[1] IN[1] IN[0] VinjNOR3_3/Input3 OUTPUT00 VGND sky130_hilas_VinjNOR3
x5 VINJ[1] IN[1] VinjNOR3_1/Input1 VinjNOR3_3/Input3 OUTPUT01 VGND sky130_hilas_VinjNOR3
x6 VINJ[1] VinjNOR3_2/Input2 IN[0] VinjNOR3_3/Input3 OUTPUT10 VGND sky130_hilas_VinjNOR3
x7 VINJ[1] VinjNOR3_2/Input2 VinjNOR3_1/Input1 VinjNOR3_3/Input3 OUTPUT11 VGND sky130_hilas_VinjNOR3
.ends

.subckt Tgate VINJ OUTPUT SELECT INPUT VGND
*.iopin VINJ
*.ipin SELECT
*.iopin INPUT
*.iopin OUTPUT
*.ipin VGND
XM5 net1 SELECT VGND VGND sky130_fd_pr__nfet_g5v0d10v5 L=0.5 W=0.42 nf=1 ad='int((nf+1)/2) * W/nf * 0.29' as='int((nf+2)/2) * W/nf * 0.29'
+ pd='2*int((nf+1)/2) * (W/nf + 0.29)' ps='2*int((nf+2)/2) * (W/nf + 0.29)' nrd='0.29 / W' nrs='0.29 / W' sa=0 sb=0 sd=0 mult=1 m=1
XM1 net1 SELECT VINJ VINJ sky130_fd_pr__pfet_g5v0d10v5 L=0.5 W=0.42 nf=1 ad='int((nf+1)/2) * W/nf * 0.29' as='int((nf+2)/2) * W/nf * 0.29'
+ pd='2*int((nf+1)/2) * (W/nf + 0.29)' ps='2*int((nf+2)/2) * (W/nf + 0.29)' nrd='0.29 / W' nrs='0.29 / W' sa=0 sb=0 sd=0 mult=1 m=1
XM2 INPUT net1 OUTPUT VINJ sky130_fd_pr__pfet_g5v0d10v5 L=0.5 W=0.42 nf=1 ad='int((nf+1)/2) * W/nf * 0.29' as='int((nf+2)/2) * W/nf * 0.29'
+ pd='2*int((nf+1)/2) * (W/nf + 0.29)' ps='2*int((nf+2)/2) * (W/nf + 0.29)' nrd='0.29 / W' nrs='0.29 / W' sa=0 sb=0 sd=0 mult=1 m=1
XM3 OUTPUT SELECT INPUT VGND sky130_fd_pr__nfet_g5v0d10v5 L=0.5 W=0.42 nf=1 ad='int((nf+1)/2) * W/nf * 0.29' as='int((nf+2)/2) * W/nf * 0.29'
+ pd='2*int((nf+1)/2) * (W/nf + 0.29)' ps='2*int((nf+2)/2) * (W/nf + 0.29)' nrd='0.29 / W' nrs='0.29 / W' sa=0 sb=0 sd=0 mult=1 m=1
.ends

*+ pins=3
.subckt sky130_hilas_resistor_string VREFin Node[3] Node[2] Node[1] Node[0] VREFout
*.iopin VREFout
*.iopin VREFin
*.opin Node[3],Node[2],Node[1],Node[0]
XR1 Node[0] VREFin sky130_fd_pr__res_generic_po W=0.33 L=10.19 m=1
XR2 net1 Node[0] sky130_fd_pr__res_generic_po W=0.33 L=10.19 m=1
XR3 Node[1] net1 sky130_fd_pr__res_generic_po W=0.33 L=10.19 m=1
XR4 net2 Node[1] sky130_fd_pr__res_generic_po W=0.33 L=10.19 m=1
XR5 Node[2] net2 sky130_fd_pr__res_generic_po W=0.33 L=10.19 m=1
XR6 net3 Node[2] sky130_fd_pr__res_generic_po W=0.33 L=10.19 m=1
XR7 Node[3] net3 sky130_fd_pr__res_generic_po W=0.33 L=10.19 m=1
XR8 VREFout Node[3] sky130_fd_pr__res_generic_po W=0.33 L=10.19 m=1
.ends

.subckt sky130_hilas_VinjInv2 Vinj Input Output GND
*.ipin Input
*.opin Output
*.iopin Vinj
*.iopin GND
XM4 Output Input Vinj Vinj sky130_fd_pr__pfet_g5v0d10v5 L=0.53 W=0.42 nf=1 ad='int((nf+1)/2) * W/nf * 0.29' as='int((nf+2)/2) * W/nf * 0.29'
+ pd='2*int((nf+1)/2) * (W/nf + 0.29)' ps='2*int((nf+2)/2) * (W/nf + 0.29)' nrd='0.29 / W' nrs='0.29 / W' sa=0 sb=0 sd=0 mult=1 m=1
XM3 Output Input GND GND sky130_fd_pr__nfet_g5v0d10v5 L=0.52 W=0.42 nf=1 ad='int((nf+1)/2) * W/nf * 0.29' as='int((nf+2)/2) * W/nf * 0.29'
+ pd='2*int((nf+1)/2) * (W/nf + 0.29)' ps='2*int((nf+2)/2) * (W/nf + 0.29)' nrd='0.29 / W' nrs='0.29 / W' sa=0 sb=0 sd=0 mult=1 m=1
.ends

.subckt sky130_hilas_VinjNOR3 Vinj Input1 Input2 Input3 OUTPUT GND
*.ipin Input3
*.ipin Input1
*.ipin Input2
*.iopin Vinj
*.iopin GND
*.opin OUTPUT
XM1 OUTPUT Input3 GND GND sky130_fd_pr__nfet_g5v0d10v5 L=0.5 W=0.42 nf=1 ad='int((nf+1)/2) * W/nf * 0.29' as='int((nf+2)/2) * W/nf * 0.29'
+ pd='2*int((nf+1)/2) * (W/nf + 0.29)' ps='2*int((nf+2)/2) * (W/nf + 0.29)' nrd='0.29 / W' nrs='0.29 / W' sa=0 sb=0 sd=0 mult=1 m=1
XM2 OUTPUT Input1 GND GND sky130_fd_pr__nfet_g5v0d10v5 L=0.51 W=0.43 nf=1 ad='int((nf+1)/2) * W/nf * 0.29' as='int((nf+2)/2) * W/nf * 0.29'
+ pd='2*int((nf+1)/2) * (W/nf + 0.29)' ps='2*int((nf+2)/2) * (W/nf + 0.29)' nrd='0.29 / W' nrs='0.29 / W' sa=0 sb=0 sd=0 mult=1 m=1
XM3 OUTPUT Input2 GND GND sky130_fd_pr__nfet_g5v0d10v5 L=0.5 W=0.42 nf=1 ad='int((nf+1)/2) * W/nf * 0.29' as='int((nf+2)/2) * W/nf * 0.29'
+ pd='2*int((nf+1)/2) * (W/nf + 0.29)' ps='2*int((nf+2)/2) * (W/nf + 0.29)' nrd='0.29 / W' nrs='0.29 / W' sa=0 sb=0 sd=0 mult=1 m=1
XM6 OUTPUT Input2 net2 Vinj sky130_fd_pr__pfet_g5v0d10v5 L=0.52 W=0.43 nf=1 ad='int((nf+1)/2) * W/nf * 0.29' as='int((nf+2)/2) * W/nf * 0.29'
+ pd='2*int((nf+1)/2) * (W/nf + 0.29)' ps='2*int((nf+2)/2) * (W/nf + 0.29)' nrd='0.29 / W' nrs='0.29 / W' sa=0 sb=0 sd=0 mult=1 m=1
XM4 net2 Input1 net1 Vinj sky130_fd_pr__pfet_g5v0d10v5 L=0.52 W=0.42 nf=1 ad='int((nf+1)/2) * W/nf * 0.29' as='int((nf+2)/2) * W/nf * 0.29'
+ pd='2*int((nf+1)/2) * (W/nf + 0.29)' ps='2*int((nf+2)/2) * (W/nf + 0.29)' nrd='0.29 / W' nrs='0.29 / W' sa=0 sb=0 sd=0 mult=1 m=1
XM5 net1 Input3 Vinj Vinj sky130_fd_pr__pfet_g5v0d10v5 L=0.53 W=0.42 nf=1 ad='int((nf+1)/2) * W/nf * 0.29' as='int((nf+2)/2) * W/nf * 0.29'
+ pd='2*int((nf+1)/2) * (W/nf + 0.29)' ps='2*int((nf+2)/2) * (W/nf + 0.29)' nrd='0.29 / W' nrs='0.29 / W' sa=0 sb=0 sd=0 mult=1 m=1
.ends

.end
