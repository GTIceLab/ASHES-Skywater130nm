.subckt TA_FGbias_1x2 Vin_P[0] Vin_P[1] Vin_M[0] Vin_M[1] Vsel VTUN Vg VINJ OUTPUT[0] OUTPUT[1] AVDD GND Vd_P[0] Vd_P[1]
*.PININFO Vin_P[0:1]:I Vin_M[0:1]:I Vsel:I VTUN:I Vg:I VINJ:I OUTPUT[0:1]:O AVDD:I GND:I Vd_P[0:1]:I
XC8 net6 VTUN GND sky130_fd_pr__cap_var W=0.59 L=0.5 m=1
XM12 net5 Vsel VINJ VINJ sky130_fd_pr__pfet_g5v0d10v5 L=0.5 W=0.42 nf=1 m=1
XM2 Vd_P[0] net6 net5 VINJ sky130_fd_pr__pfet_g5v0d10v5 L=0.5 W=0.42 nf=1 m=1
XC1 net6 Vg GND sky130_fd_pr__cap_var W=1.11 L=0.5 m=1
XM1 net1 net6 AVDD VINJ sky130_fd_pr__pfet_g5v0d10v5 L=2 W=2 nf=1 m=1
XM10 OUTPUT[0] net3 AVDD AVDD sky130_fd_pr__pfet_01v8 L=0.6 W=1 nf=1 m=1
XM7 AVDD net3 net3 AVDD sky130_fd_pr__pfet_01v8 L=0.6 W=1 nf=1 m=1
XM11 net1 Vin_P[0] net4 AVDD sky130_fd_pr__pfet_01v8 L=0.15 W=5 nf=1 m=1
XM5 net2 Vin_M[0] net1 AVDD sky130_fd_pr__pfet_01v8 L=0.15 W=5 nf=1 m=1
XM4 net2 net2 GND GND sky130_fd_pr__nfet_01v8 L=0.6 W=1 nf=1 m=1
XM3 GND net2 net3 GND sky130_fd_pr__nfet_01v8 L=0.6 W=1 nf=1 m=1
XM6 GND net4 net4 GND sky130_fd_pr__nfet_01v8 L=0.6 W=1 nf=1 m=1
XM8 OUTPUT[0] net4 GND GND sky130_fd_pr__nfet_01v8 L=0.6 W=1 nf=1 m=1
XC2 net12 VTUN GND sky130_fd_pr__cap_var W=0.59 L=0.5 m=1
XM9 net11 Vsel VINJ VINJ sky130_fd_pr__pfet_g5v0d10v5 L=0.5 W=0.42 nf=1 m=1
XM13 Vd_P[1] net12 net11 VINJ sky130_fd_pr__pfet_g5v0d10v5 L=0.5 W=0.42 nf=1 m=1
XC3 net12 Vg GND sky130_fd_pr__cap_var W=1.11 L=0.5 m=1
XM14 net7 net12 AVDD VINJ sky130_fd_pr__pfet_g5v0d10v5 L=2 W=2 nf=1 m=1
XM15 OUTPUT[1] net9 AVDD AVDD sky130_fd_pr__pfet_01v8 L=0.6 W=1 nf=1 m=1
XM16 AVDD net9 net9 AVDD sky130_fd_pr__pfet_01v8 L=0.6 W=1 nf=1 m=1
XM17 net7 Vin_P[1] net10 AVDD sky130_fd_pr__pfet_01v8 L=0.15 W=5 nf=1 m=1
XM18 net8 Vin_M[1] net7 AVDD sky130_fd_pr__pfet_01v8 L=0.15 W=5 nf=1 m=1
XM19 net8 net8 GND GND sky130_fd_pr__nfet_01v8 L=0.6 W=1 nf=1 m=1
XM20 GND net8 net9 GND sky130_fd_pr__nfet_01v8 L=0.6 W=1 nf=1 m=1
XM21 GND net10 net10 GND sky130_fd_pr__nfet_01v8 L=0.6 W=1 nf=1 m=1
XM22 OUTPUT[1] net10 GND GND sky130_fd_pr__nfet_01v8 L=0.6 W=1 nf=1 m=1
.ends
