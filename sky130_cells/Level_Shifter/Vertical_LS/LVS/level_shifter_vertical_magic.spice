* NGSPICE file created from level_shifter_vertical.ext - technology: sky130A

.subckt level_shifter_vertical GND Vgrun[0] Vgrun[1] Vhi Vin[0] Vin[1] Vlow Vout[0]
+ Vout[1] Vout_B[0] Vout_B[1] VTUN
X0 a_8780_3820# a_8780_3270# Vhi Vhi sky130_fd_pr__pfet_g5v0d10v5 ad=0.9 pd=4.9 as=1 ps=4.8 w=2 l=0.5
**devattr s=40000,1000 d=36000,980
X1 Vhi a_8780_3820# a_8780_3270# Vhi sky130_fd_pr__pfet_g5v0d10v5 ad=1 pd=4.8 as=1 ps=5 w=2 l=0.5
**devattr s=40000,1000 d=40000,1000
X2 GND a_7410_3360# Vout[0] GND sky130_fd_pr__nfet_g5v0d10v5 ad=0.46667 pd=2.42222 as=0.5 ps=3 w=1 l=0.5
**devattr s=20000,600 d=20000,600
X3 Vout[0] a_7410_3360# Vhi Vhi sky130_fd_pr__pfet_g5v0d10v5 ad=1 pd=5 as=1 ps=4.8 w=2 l=0.5
**devattr s=40000,1000 d=40000,1000
X4 a_7982_3380# Vin[0] GND GND sky130_fd_pr__nfet_01v8 ad=0.4 pd=2.8 as=0.4 ps=2.8 w=1 l=0.15
**devattr s=16000,560 d=16000,560
X5 Vlow Vin[0] a_7982_3380# Vlow sky130_fd_pr__pfet_01v8 ad=0.4 pd=2.8 as=0.4 ps=2.8 w=1 l=0.15
**devattr s=16000,560 d=16000,560
X6 Vhi Vout[0] Vout_B[0] Vhi sky130_fd_pr__pfet_g5v0d10v5 ad=2 pd=9.6 as=2 ps=9 w=4 l=0.5
**devattr s=80000,1800 d=80000,1800
X7 GND Vout[1] Vout_B[1] GND sky130_fd_pr__nfet_g5v0d10v5 ad=0.93333 pd=4.84444 as=1 ps=5 w=2 l=0.5
**devattr s=40000,1000 d=40000,1000
X8 a_7410_3360# Vin[0] GND GND sky130_fd_pr__nfet_g5v0d10v5 ad=1.35 pd=6.9 as=1.4 ps=7.26667 w=3 l=0.5
**devattr s=54000,1380 d=54000,1380
X9 a_8780_3820# Vin[1] GND GND sky130_fd_pr__nfet_g5v0d10v5 ad=1.35 pd=6.9 as=1.4 ps=7.26667 w=3 l=0.5
**devattr s=54000,1380 d=54000,1380
X10 GND Vin[1] a_8750_3360# GND sky130_fd_pr__nfet_01v8 ad=0.4 pd=2.8 as=0.4 ps=2.8 w=1 l=0.15
**devattr s=16000,560 d=16000,560
X11 GND a_7982_3380# a_7410_3720# GND sky130_fd_pr__nfet_g5v0d10v5 ad=1.4 pd=7.26667 as=1.35 ps=6.9 w=3 l=0.5
**devattr s=54000,1380 d=54000,1380
X12 GND a_8750_3360# a_8780_3270# GND sky130_fd_pr__nfet_g5v0d10v5 ad=1.4 pd=7.26667 as=1.35 ps=6.9 w=3 l=0.5
**devattr s=54000,1380 d=54000,1380
X13 Vout_B[1] Vout[1] Vhi Vhi sky130_fd_pr__pfet_g5v0d10v5 ad=2 pd=9 as=2 ps=9.6 w=4 l=0.5
**devattr s=80000,1800 d=80000,1800
X14 a_7410_3360# a_7410_3720# Vhi Vhi sky130_fd_pr__pfet_g5v0d10v5 ad=0.9 pd=4.9 as=1 ps=4.8 w=2 l=0.5
**devattr s=40000,1000 d=36000,980
X15 Vhi a_7410_3360# a_7410_3720# Vhi sky130_fd_pr__pfet_g5v0d10v5 ad=1 pd=4.8 as=1 ps=5 w=2 l=0.5
**devattr s=40000,1000 d=40000,1000
X16 Vout[1] a_8780_3820# Vhi Vhi sky130_fd_pr__pfet_g5v0d10v5 ad=1 pd=5 as=1 ps=4.8 w=2 l=0.5
**devattr s=40000,1000 d=40000,1000
X17 a_8750_3360# Vin[1] Vlow Vlow sky130_fd_pr__pfet_01v8 ad=0.4 pd=2.8 as=0.4 ps=2.8 w=1 l=0.15
**devattr s=16000,560 d=16000,560
X18 GND a_8780_3820# Vout[1] GND sky130_fd_pr__nfet_g5v0d10v5 ad=0.46667 pd=2.42222 as=0.5 ps=3 w=1 l=0.5
**devattr s=20000,600 d=20000,600
X19 GND Vout[0] Vout_B[0] GND sky130_fd_pr__nfet_g5v0d10v5 ad=0.93333 pd=4.84444 as=1 ps=5 w=2 l=0.5
**devattr s=40000,1000 d=40000,1000
.ends
