* NGSPICE file created from IndirectVMM_Top_AorBmat_4x2.ext - technology: sky130A

.subckt IndirectVMM_Top_AorBmat_4x2 Vd_P[3] Vd_R[3] Vd_R[2] Vd_P[2] Vd_P[1] Vd_R[1]
+ Vd_P[0] Vs GND Vg VTUN VINJ Vsel fgmem[0] fgmem[1]
X0 VINJ Vsel Vmid[3] VINJ sky130_fd_pr__pfet_g5v0d10v5 ad=0.1155 pd=1.39 as=0.0714 ps=0.76 w=0.42 l=0.5
**devattr s=714,76 d=1176,140
X1 FG[1] VTUN GND sky130_fd_pr__cap_var w=0.29 l=0.5
X2 FG[1] VTUN GND sky130_fd_pr__cap_var w=0.29 l=0.5
X3 FG[0] Vg GND sky130_fd_pr__cap_var w=0.54 l=0.65
X4 Vmid[1] FG[1] Vd_P[1] VINJ sky130_fd_pr__pfet_g5v0d10v5 ad=0.078 pd=0.83 as=0.1176 ps=1.4 w=0.42 l=0.5
**devattr s=1176,140 d=780,83
X5 Vs FG[2] Vd_R[2] VINJ sky130_fd_pr__pfet_g5v0d10v5 ad=0.08285 pd=0.895 as=0.1176 ps=1.4 w=0.42 l=0.5
**devattr s=1176,140 d=824,89
X6 FG[3] Vg GND sky130_fd_pr__cap_var w=0.54 l=0.65
X7 FG[0] Vg GND sky130_fd_pr__cap_var w=0.54 l=0.65
X8 Vd_R[2] FG[2] Vs VINJ sky130_fd_pr__pfet_g5v0d10v5 ad=0.1176 pd=1.4 as=0.08285 ps=0.895 w=0.42 l=0.5
**devattr s=824,89 d=1176,140
X9 Vd_P[1] FG[1] Vmid[1] VINJ sky130_fd_pr__pfet_g5v0d10v5 ad=0.1176 pd=1.4 as=0.078 ps=0.83 w=0.42 l=0.5
**devattr s=780,83 d=1176,140
X10 Vd_P[0] FG[0] Vmid[0] VINJ sky130_fd_pr__pfet_g5v0d10v5 ad=0.1134 pd=1.38 as=0.0735 ps=0.77 w=0.42 l=0.5
**devattr s=735,77 d=1134,138
X11 VINJ Vsel Vmid[2] VINJ sky130_fd_pr__pfet_g5v0d10v5 ad=0.1155 pd=1.39 as=0.0839 ps=0.9 w=0.42 l=0.5
**devattr s=839,90 d=1134,138
X12 FG[0] VTUN GND sky130_fd_pr__cap_var w=0.29 l=0.5
X13 FG[0] VTUN GND sky130_fd_pr__cap_var w=0.29 l=0.5
X14 fgmem[0] FG[0] Vs VINJ sky130_fd_pr__pfet_g5v0d10v5 ad=0.1134 pd=1.38 as=0.08285 ps=0.895 w=0.42 l=0.5
**devattr s=832,90 d=1134,138
X15 VINJ Vsel Vmid[1] VINJ sky130_fd_pr__pfet_g5v0d10v5 ad=0.1155 pd=1.39 as=0.078 ps=0.83 w=0.42 l=0.5
**devattr s=780,83 d=1134,138
X16 Vmid[0] Vsel VINJ VINJ sky130_fd_pr__pfet_g5v0d10v5 ad=0.0735 pd=0.77 as=0.1155 ps=1.39 w=0.42 l=0.5
**devattr s=1176,140 d=735,77
X17 Vmid[3] Vsel VINJ VINJ sky130_fd_pr__pfet_g5v0d10v5 ad=0.0714 pd=0.76 as=0.1155 ps=1.39 w=0.42 l=0.5
**devattr s=1176,140 d=714,76
X18 VINJ Vsel Vmid[0] VINJ sky130_fd_pr__pfet_g5v0d10v5 ad=0.1155 pd=1.39 as=0.0735 ps=0.77 w=0.42 l=0.5
**devattr s=735,77 d=1176,140
X19 FG[3] Vg GND sky130_fd_pr__cap_var w=0.54 l=0.65
X20 FG[3] VTUN GND sky130_fd_pr__cap_var w=0.29 l=0.5
X21 Vmid[0] FG[0] Vd_P[0] VINJ sky130_fd_pr__pfet_g5v0d10v5 ad=0.0735 pd=0.77 as=0.1134 ps=1.38 w=0.42 l=0.5
**devattr s=1134,138 d=735,77
X22 Vmid[2] Vsel VINJ VINJ sky130_fd_pr__pfet_g5v0d10v5 ad=0.0839 pd=0.9 as=0.1155 ps=1.39 w=0.42 l=0.5
**devattr s=1134,138 d=839,90
X23 FG[2] Vg GND sky130_fd_pr__cap_var w=0.54 l=0.65
X24 FG[2] Vg GND sky130_fd_pr__cap_var w=0.54 l=0.65
X25 Vs FG[3] Vd_R[3] VINJ sky130_fd_pr__pfet_g5v0d10v5 ad=0.08285 pd=0.895 as=0.1176 ps=1.4 w=0.42 l=0.5
**devattr s=1176,140 d=824,89
X26 Vmid[3] FG[3] Vd_P[3] VINJ sky130_fd_pr__pfet_g5v0d10v5 ad=0.0714 pd=0.76 as=0.1176 ps=1.4 w=0.42 l=0.5
**devattr s=1176,140 d=714,76
X27 Vs FG[0] fgmem[1] VINJ sky130_fd_pr__pfet_g5v0d10v5 ad=0.08285 pd=0.895 as=0.1134 ps=1.38 w=0.42 l=0.5
**devattr s=1134,138 d=832,90
X28 Vmid[2] FG[2] Vd_P[2] VINJ sky130_fd_pr__pfet_g5v0d10v5 ad=0.0839 pd=0.9 as=0.1176 ps=1.4 w=0.42 l=0.5
**devattr s=1176,140 d=839,90
X29 Vd_P[2] FG[2] Vmid[2] VINJ sky130_fd_pr__pfet_g5v0d10v5 ad=0.1176 pd=1.4 as=0.0839 ps=0.9 w=0.42 l=0.5
**devattr s=839,90 d=1176,140
X30 Vs FG[1] Vd_R[1] VINJ sky130_fd_pr__pfet_g5v0d10v5 ad=0.08285 pd=0.895 as=0.1176 ps=1.4 w=0.42 l=0.5
**devattr s=1176,140 d=832,90
X31 FG[2] VTUN GND sky130_fd_pr__cap_var w=0.29 l=0.5
X32 Vd_R[1] FG[1] Vs VINJ sky130_fd_pr__pfet_g5v0d10v5 ad=0.1176 pd=1.4 as=0.08285 ps=0.895 w=0.42 l=0.5
**devattr s=832,90 d=1176,140
X33 FG[2] VTUN GND sky130_fd_pr__cap_var w=0.29 l=0.5
X34 FG[3] VTUN GND sky130_fd_pr__cap_var w=0.29 l=0.5
X35 FG[1] Vg GND sky130_fd_pr__cap_var w=0.54 l=0.65
X36 Vd_R[3] FG[3] Vs VINJ sky130_fd_pr__pfet_g5v0d10v5 ad=0.1176 pd=1.4 as=0.08285 ps=0.895 w=0.42 l=0.5
**devattr s=824,89 d=1176,140
X37 FG[1] Vg GND sky130_fd_pr__cap_var w=0.54 l=0.65
X38 Vmid[1] Vsel VINJ VINJ sky130_fd_pr__pfet_g5v0d10v5 ad=0.078 pd=0.83 as=0.1155 ps=1.39 w=0.42 l=0.5
**devattr s=1134,138 d=780,83
X39 Vd_P[3] FG[3] Vmid[3] VINJ sky130_fd_pr__pfet_g5v0d10v5 ad=0.1176 pd=1.4 as=0.0714 ps=0.76 w=0.42 l=0.5
**devattr s=714,76 d=1176,140
.ends
