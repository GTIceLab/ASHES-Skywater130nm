* NGSPICE file created from Volatile_Swcs.ext - technology: sky130A

.subckt FG_Indirect VINJ Vs Vg VTUN GND Vsel Vd_R Vd_P
X0 Vd_R FG Vs VINJ sky130_fd_pr__pfet_g5v0d10v5 ad=0.1134 pd=1.38 as=0.1134 ps=1.38 w=0.42 l=0.5
**devattr s=4536,276 d=4536,276
X1 Vd_P FG Vmid VINJ sky130_fd_pr__pfet_g5v0d10v5 ad=0.1134 pd=1.38 as=0.0735 ps=0.77 w=0.42 l=0.5
**devattr s=2940,154 d=4536,276
X2 FG Vg GND sky130_fd_pr__cap_var w=0.54 l=0.65
X3 Vmid Vsel VINJ VINJ sky130_fd_pr__pfet_g5v0d10v5 ad=0.0735 pd=0.77 as=0.1176 ps=1.4 w=0.42 l=0.5
**devattr s=4704,280 d=2940,154
X4 FG VTUN GND sky130_fd_pr__cap_var w=0.29 l=0.5
.ends

.subckt x130nm_nmos_freeBody a_n40_n30# a_n140_0# a_n10_0# VSUBS
X0 a_n10_0# a_n40_n30# a_n140_0# VSUBS sky130_fd_pr__nfet_01v8 ad=0.5 pd=3 as=0.5 ps=3 w=1 l=0.15
**devattr s=20000,600 d=20000,600
.ends

.subckt x130nm_pmos_freeBody a_n140_n410# a_n10_n410# a_n40_n440# w_n180_n450#
X0 a_n10_n410# a_n40_n440# a_n140_n410# w_n180_n450# sky130_fd_pr__pfet_01v8 ad=1 pd=5 as=1 ps=5 w=2 l=0.15
**devattr s=40000,1000 d=40000,1000
.ends

.subckt sky130_fd_sc_hd__dfrbp_1 VGND VPWR VPB VNB CLK D RESET_B Q Q_N
X0 Q a_1283_21# VPWR VPB sky130_fd_pr__pfet_01v8_hvt ad=0.28 pd=2.56 as=0.21144 ps=1.99451 w=1 l=0.15
**devattr s=8528,334 d=11200,512
X1 a_805_47# a_761_289# a_639_47# VNB sky130_fd_pr__nfet_01v8 ad=0.0441 pd=0.63 as=0.15088 ps=1.18462 w=0.42 l=0.15
**devattr s=5604,220 d=1764,126
X2 VPWR a_1283_21# a_1847_47# VPB sky130_fd_pr__pfet_01v8_hvt ad=0.13532 pd=1.27648 as=0.1664 ps=1.8 w=0.64 l=0.15
**devattr s=6656,360 d=6160,267
X3 a_1217_47# a_27_47# a_1108_47# VNB sky130_fd_pr__special_nfet_01v8 ad=0.06175 pd=0.69231 as=0.0711 ps=0.755 w=0.36 l=0.15
**devattr s=2844,151 d=2676,150
X4 a_1283_21# a_1108_47# a_1462_47# VNB sky130_fd_pr__nfet_01v8 ad=0.1092 pd=1.36 as=0.06405 ps=0.725 w=0.42 l=0.15
**devattr s=2562,145 d=4368,272
X5 a_651_413# a_27_47# a_543_47# VPB sky130_fd_pr__pfet_01v8_hvt ad=0.1134 pd=1.1 as=0.07245 ps=0.765 w=0.42 l=0.15
**devattr s=2898,153 d=4620,194
X6 a_1108_47# a_193_47# a_761_289# VNB sky130_fd_pr__special_nfet_01v8 ad=0.0711 pd=0.755 as=0.07193 ps=0.7092 w=0.36 l=0.15
**devattr s=3996,197 d=2844,151
X7 VGND RESET_B a_805_47# VNB sky130_fd_pr__nfet_01v8 ad=0.10522 pd=0.98029 as=0.0441 ps=0.63 w=0.42 l=0.15
**devattr s=1764,126 d=5384,230
X8 VPWR CLK a_27_47# VPB sky130_fd_pr__pfet_01v8_hvt ad=0.13532 pd=1.27648 as=0.1664 ps=1.8 w=0.64 l=0.15
**devattr s=6656,360 d=3456,182
X9 Q_N a_1847_47# VGND VNB sky130_fd_pr__nfet_01v8 ad=0.169 pd=1.82 as=0.16283 ps=1.51711 w=0.65 l=0.15
**devattr s=4010,197 d=6760,364
X10 a_448_47# D VPWR VPB sky130_fd_pr__pfet_01v8_hvt ad=0.0651 pd=0.73 as=0.08881 ps=0.83769 w=0.42 l=0.15
**devattr s=4368,272 d=2604,146
X11 VGND a_1283_21# a_1847_47# VNB sky130_fd_pr__nfet_01v8 ad=0.10522 pd=0.98029 as=0.1092 ps=1.36 w=0.42 l=0.15
**devattr s=4368,272 d=4010,197
X12 a_761_289# a_543_47# VGND VNB sky130_fd_pr__nfet_01v8 ad=0.12787 pd=1.2608 as=0.16033 ps=1.49377 w=0.64 l=0.15
**devattr s=5384,230 d=3996,197
X13 Q a_1283_21# VGND VNB sky130_fd_pr__nfet_01v8 ad=0.169 pd=1.82 as=0.16283 ps=1.51711 w=0.65 l=0.15
**devattr s=6760,364 d=6760,364
X14 a_193_47# a_27_47# VGND VNB sky130_fd_pr__nfet_01v8 ad=0.1092 pd=1.36 as=0.10522 ps=0.98029 w=0.42 l=0.15
**devattr s=2268,138 d=4368,272
X15 a_1108_47# a_27_47# a_761_289# VPB sky130_fd_pr__pfet_01v8_hvt ad=0.0588 pd=0.7 as=0.0861 ps=0.79 w=0.42 l=0.15
**devattr s=5166,237 d=2352,140
X16 a_1462_47# RESET_B VGND VNB sky130_fd_pr__nfet_01v8 ad=0.06405 pd=0.725 as=0.10522 ps=0.98029 w=0.42 l=0.15
**devattr s=4998,203 d=2562,145
X17 a_543_47# a_27_47# a_448_47# VNB sky130_fd_pr__special_nfet_01v8 ad=0.0594 pd=0.69 as=0.06092 ps=0.68769 w=0.36 l=0.15
**devattr s=2640,149 d=2376,138
X18 a_543_47# a_193_47# a_448_47# VPB sky130_fd_pr__pfet_01v8_hvt ad=0.07245 pd=0.765 as=0.0651 ps=0.73 w=0.42 l=0.15
**devattr s=2604,146 d=2898,153
X19 a_448_47# D VGND VNB sky130_fd_pr__nfet_01v8 ad=0.07108 pd=0.80231 as=0.10522 ps=0.98029 w=0.42 l=0.15
**devattr s=8820,378 d=2640,149
X20 VPWR a_1283_21# a_1270_413# VPB sky130_fd_pr__pfet_01v8_hvt ad=0.08881 pd=0.83769 as=0.0567 ps=0.69 w=0.42 l=0.15
**devattr s=2268,138 d=3276,162
X21 VPWR a_1108_47# a_1283_21# VPB sky130_fd_pr__pfet_01v8_hvt ad=0.08881 pd=0.83769 as=0.0567 ps=0.69 w=0.42 l=0.15
**devattr s=2268,138 d=8528,334
X22 a_1270_413# a_193_47# a_1108_47# VPB sky130_fd_pr__pfet_01v8_hvt ad=0.0567 pd=0.69 as=0.0588 ps=0.7 w=0.42 l=0.15
**devattr s=2352,140 d=2268,138
X23 a_193_47# a_27_47# VPWR VPB sky130_fd_pr__pfet_01v8_hvt ad=0.1664 pd=1.8 as=0.13532 ps=1.27648 w=0.64 l=0.15
**devattr s=3456,182 d=6656,360
X24 a_1283_21# RESET_B VPWR VPB sky130_fd_pr__pfet_01v8_hvt ad=0.0567 pd=0.69 as=0.08881 ps=0.83769 w=0.42 l=0.15
**devattr s=3276,162 d=2268,138
X25 VPWR a_761_289# a_651_413# VPB sky130_fd_pr__pfet_01v8_hvt ad=0.08881 pd=0.83769 as=0.1134 ps=1.1 w=0.42 l=0.15
**devattr s=4620,194 d=2814,151
X26 a_639_47# a_193_47# a_543_47# VNB sky130_fd_pr__special_nfet_01v8 ad=0.12932 pd=1.01538 as=0.0594 ps=0.69 w=0.36 l=0.15
**devattr s=2376,138 d=5604,220
X27 Q_N a_1847_47# VPWR VPB sky130_fd_pr__pfet_01v8_hvt ad=0.26 pd=2.52 as=0.21144 ps=1.99451 w=1 l=0.15
**devattr s=6160,267 d=10400,504
X28 VGND a_1283_21# a_1217_47# VNB sky130_fd_pr__nfet_01v8 ad=0.10522 pd=0.98029 as=0.07205 ps=0.80769 w=0.42 l=0.15
**devattr s=2676,150 d=4998,203
X29 a_651_413# RESET_B VPWR VPB sky130_fd_pr__pfet_01v8_hvt ad=0.1134 pd=1.1 as=0.08881 ps=0.83769 w=0.42 l=0.15
**devattr s=2814,151 d=4368,272
X30 VGND CLK a_27_47# VNB sky130_fd_pr__nfet_01v8 ad=0.10522 pd=0.98029 as=0.1092 ps=1.36 w=0.42 l=0.15
**devattr s=4368,272 d=2268,138
X31 a_761_289# a_543_47# VPWR VPB sky130_fd_pr__pfet_01v8_hvt ad=0.1722 pd=1.58 as=0.17761 ps=1.67538 w=0.84 l=0.15
**devattr s=8736,440 d=5166,237
.ends

.subckt Volatile_Swcs RST_b D Vin[1] Vsel[1] Vsel[0] Vin[0] Vg[0] Vg[1] VTUN GND Q
+ VINJ VDD Vd_P CLK Scan_Vout
XFG_Indirect_0 VINJ Vin[0] Vg[0] VTUN GND Vsel[0] FG_Indirect_0/Vd_R Vd_P FG_Indirect
XFG_Indirect_1 VINJ Vin[1] Vg[1] VTUN GND Vsel[1] FG_Indirect_1/Vd_R Vd_P FG_Indirect
X130nm_nmos_freeBody_0 Q Scan_Vout FG_Indirect_1/Vd_R GND x130nm_nmos_freeBody
X130nm_nmos_freeBody_1 sky130_fd_sc_hd__dfrbp_1_1/Q FG_Indirect_0/Vd_R Scan_Vout GND
+ x130nm_nmos_freeBody
X130nm_pmos_freeBody_0 Scan_Vout FG_Indirect_0/Vd_R sky130_fd_sc_hd__dfrbp_1_1/Q_N
+ VDD x130nm_pmos_freeBody
X130nm_pmos_freeBody_1 Scan_Vout FG_Indirect_1/Vd_R sky130_fd_sc_hd__dfrbp_1_0/Q_N
+ VDD x130nm_pmos_freeBody
Xsky130_fd_sc_hd__dfrbp_1_0 GND VDD VDD GND CLK sky130_fd_sc_hd__dfrbp_1_1/Q RST_b
+ Q sky130_fd_sc_hd__dfrbp_1_0/Q_N sky130_fd_sc_hd__dfrbp_1
Xsky130_fd_sc_hd__dfrbp_1_1 GND VDD VDD GND CLK D RST_b sky130_fd_sc_hd__dfrbp_1_1/Q
+ sky130_fd_sc_hd__dfrbp_1_1/Q_N sky130_fd_sc_hd__dfrbp_1
.ends
